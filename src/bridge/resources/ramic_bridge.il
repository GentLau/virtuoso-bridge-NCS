;RB = RAMIC Bridge
;RBD = RB Daemon
;
; This file is the whole bottom layer for Skill execution: daemon lifecycle
; (RBStart/RBStop/RBStopAll), the IPC handlers and the per-request CDS.log
; capture.  The CIW monitor form, the banner menu and the cosmetic helpers
; live in the optional companion ``ramic_bridge_ui.il``, which
; virtuoso_setup.il loads right after this file.  The dependency is one-way:
; the UI reads the globals/procedures here, and the only hook from here into
; the UI is the guarded repaint
; ``when(boundp('RBMonInstalled) errset(RBMRefresh()))``.  Deploy this file
; without the companion and everything below still runs.

; Configuration variables — injected by virtuoso_setup.il as SKILL globals;
; fallback defaults allow standalone load for debugging.
unless(boundp('RBDPath) RBDPath = "./ramic_bridge_daemon.py")
unless(boundp('RBPython) RBPython = "python")
unless(boundp('RBPort) RBPort = 65432)
unless(boundp('RBIdentityPath) RBIdentityPath = "")
unless(boundp('RBDToken) RBDToken = nil)
unless(boundp('RBTempDir) RBTempDir = "")
unless(boundp('RBDLogPath) RBDLogPath = if(RBTempDir strcat(RBTempDir "/RB.log") ""))
; Per-request directive set by daemon.py before the SKILL text:
; t  -> capture CDS.log [start,end) without injecting any output into CDS.log
; nil -> behave exactly like the old no-log code path (no flush/fileLength)
unless(boundp('RBDLogOn) RBDLogOn = nil)
RBLocal = nil                                                                      ; Local-only connections (127.0.0.1 vs 0.0.0.0)
RBEcho = nil                                                                     ; Echo bridging messages for debugging
RBDLog = nil                                                                     ; Enable daemon logging to RBDLogPath

; IPC process handle. Do not reset on reload: a live daemon keeps the port;
; clearing RBIpc would make RBStart spawn a second daemon -> bind failure (exit 1).
unless(boundp('RBIpc) RBIpc = 'unbound)

; Ring buffer for daemon stderr; flushed to CIW only on non-zero exit.
unless(boundp('RBStderrBuf) RBStderrBuf = "")

; Last known daemon OS pid + bind address + remote hostname.  Populated
; by RBIpcErrHandler when it parses the daemon's startup banner; reused
; by Refresh / Finish / Stop so post-mortem messages keep showing
; pid/host/port even after the IPC handle has been freed.
unless(boundp('RBLastPid) RBLastPid = nil)
unless(boundp('RBLastBind) RBLastBind = "")
unless(boundp('RBLastHost) RBLastHost = "")
unless(boundp('RBLastUser) RBLastUser = "")
unless(boundp('RBLastIP) RBLastIP = "")

; Daemon-reported runtime stats (counter / errors / uptime in seconds).
; Updated by RBIpcErrHandler when the daemon emits a [RB-stat] line.
unless(boundp('RBStatCount) RBStatCount = 0)
unless(boundp('RBStatErrors) RBStatErrors = 0)
unless(boundp('RBStatUptime) RBStatUptime = 0)

; Persist the daemon banner next to the generated setup file.  The CLI can
; read this through the deployment/GUI host even when its TCP tunnel points
; at the wrong machine, which makes split-host bootstrap failures diagnosable.
procedure(RBWriteIdentity()
    when(RBIdentityPath && strlen(RBIdentityPath) > 0
        errset(
            let((port)
                port = outfile(RBIdentityPath)
                when(port
                    fprintf(port "host=%s\nip=%s\npid=%L\nbind=%s\nuser=%s\n"
                        RBLastHost RBLastIP RBLastPid RBLastBind RBLastUser)
                    close(port)))))
)

procedure(RBIpcDataHandler(ipcId data)
  ; Handler for successful data received from the Python daemon.
  ; Code is executed via evalstring(), which bypasses CIW's interactive loop.
  ; As a result, CIW output (printf) is line-buffered: only text ending with
  ; "\n" is committed to CIW/CDS.log immediately.  Without "\n", output stays
  ; in the buffer; hiFlush/hiFlushInfo/hiFlushCIW/drain(poport) only repaint or
  ; empty the SKILL port buffer and do NOT commit the partial line (verified
  ; on IC618).  This differs from typing directly in CIW, where the
  ; interactive loop terminates the output line after every command.
  ;
  ; We wrap data in (progn ...) so multi-statement payloads run all the
  ; way through.  Bare evalstring() parses ONE form and silently drops
  ; the rest -- callers who paste multi-statement SKILL would see only
  ; the first form take effect.  The progn wrap is a no-op for
  ; single-form input and returns the last form's value for multi-form
  ; input, matching what every Python caller already expects.
  ;
  ; CDS.log delta: no BEGIN/END markers are ever written.  When RBDLogOn
  ; is nil, this handler does exactly the old no-log work (no flush, no
  ; fileLength, no meta frame).  When RBDLogOn is t, it first terminates
  ; the pending output line (same as the interactive loop), then captures
  ; the byte offsets around the SKILL execution and sends one meta frame:
  ; STX + path + US + start + US + end + RS.
    let((result lp lo_start lo_end frames log_on)
    when(RBEcho printf("[RAMIC Bridge (%L)] receive:%L\n" ipcId data))
    lp = "" lo_start = 0 lo_end = 0
    ; the daemon prefixes the per-request directive into data itself, so the
    ; FIRST log request already captures the start offset.  Read the flag from
    ; that *prefix* only: scanning the whole payload would let user SKILL text
    ; containing "RBDLogOn=t " switch log capture on even though the daemon said
    ; RBDLogOn=nil, which breaks "off = 完全不取日志" (extra flush/fileLength/
    ; meta frame) and desyncs the frame pipe.
    log_on = equal(substring(data 1 11) "RBDLogOn=t ")
    when(log_on
        errset(hiFlushLogFile())
        errset(progn(lp = hiGetLogFileName() lo_start = fileLength(lp)))
    )
    if(errset(result=evalstring(strcat("(progn " data ")"))) then
        ; Success: STX + %L value + RS
        frames = sprintf(nil "%c%L%c" intToChar(2) result intToChar(30))
        when(RBEcho printf("[RAMIC Bridge (%L)] return:%L\n" ipcId result))
    else
        ; Error: NAK + payload，不打印 CIW
        frames = sprintf(nil "%c%L%c" intToChar(21) errset.errset intToChar(30))
    )
    when(log_on
        ; evalstring bypasses CIW's interactive loop, which terminates every
        ; command's output line with a newline.  Without that terminator a
        ; partial line (e.g. print without "\n") stays buffered: it is not
        ; displayed and only enters CDS.log when a later request writes one.
        ; Emit the same terminator so this request owns and can return its
        ; output.  The daemon drops the empty "\o \n" line it creates when
        ; the request produced no pending output.
        errset(printf("\n"))
        errset(hiFlushInfo())
        errset(hiFlushLogFile())
        errset(progn(lp = hiGetLogFileName() lo_end = fileLength(lp)))
        frames = strcat(frames
            sprintf(nil "%c%s%c%d%c%d%c"
                intToChar(2) lp intToChar(31) lo_start intToChar(31) lo_end intToChar(30)))
    )
    ; value frame and log-meta frame must arrive as ONE ipc write, otherwise
    ; CIW buffering can reorder the two frames under load
    ipcWriteProcess(ipcId frames)
  )
)

procedure(RBIpcErrHandler(ipcId data)
    ; Buffer daemon stderr; emitted to CIW only on non-zero exit
    ; (RBIpcFinishHandler). Avoids flooding CIW with routine startup
    ; chatter / Python warnings while preserving fatal-error context.
    RBStderrBuf = strcat(RBStderrBuf data)
    when(strlen(RBStderrBuf) > 8192
        RBStderrBuf = substring(RBStderrBuf strlen(RBStderrBuf)-8191 8192))
    ; Parse the daemon's startup banner ("[RB-banner] pid=N bind=H:P")
    ; from stderr.  Plain SKILL string ops only -- pcreSubstring is
    ; not available on every IC6.1.x install, and SKILL-level ``index``
    ; returns the matched suffix (not a position).  We tokenise on
    ; whitespace and pluck the pid=/bind= tokens.
    ;
    ; Note: SKILL string-literal escapes (\t, \n) are not honoured
    ; consistently across IC builds when used inside parseString's
    ; separator argument -- on this IC6.1.8 install ``" \t\n"`` does
    ; NOT split on newline.  We build the separator with explicit
    ; char codes (TAB=9, LF=10) so behaviour is identical everywhere.
    let((sep saw_banner saw_stat prevPid)
        sep = strcat(" "
                     buildString(list(intToChar(9)))
                     buildString(list(intToChar(10))))
        prevPid = RBLastPid
        saw_banner = member("[RB-banner]" parseString(data sep))
        saw_stat = member("[RB-stat]" parseString(data sep))
        ; Parse [RB-stat] count=N errors=K uptime=Ts (latest one wins;
        ; the daemon emits these throttled to ~1 Hz).
        when(saw_stat
            foreach(tok parseString(data sep)
                when(strlen(tok) > 6 && equal(substring(tok 1 6) "count=")
                    RBStatCount = atoi(substring(tok 7)))
                when(strlen(tok) > 7 && equal(substring(tok 1 7) "errors=")
                    RBStatErrors = atoi(substring(tok 8)))
                when(strlen(tok) > 7 && equal(substring(tok 1 7) "uptime=")
                    RBStatUptime = atoi(substring(tok 8))))
            when(boundp('RBMonInstalled) errset(RBMRefresh())))
        when(saw_banner
            foreach(tok parseString(data sep)
                when(strlen(tok) > 4 && equal(substring(tok 1 4) "pid=")
                    RBLastPid = atoi(substring(tok 5)))
                when(strlen(tok) > 5 && equal(substring(tok 1 5) "bind=")
                    RBLastBind = substring(tok 6))
                when(strlen(tok) > 5 && equal(substring(tok 1 5) "host=")
                    RBLastHost = substring(tok 6))
                when(strlen(tok) > 5 && equal(substring(tok 1 5) "user=")
                    RBLastUser = substring(tok 6))
                when(strlen(tok) > 3 && equal(substring(tok 1 3) "ip=")
                    RBLastIP = substring(tok 4)))
            RBWriteIdentity()
            ; First banner of this daemon's lifetime --> announce
            ; "ready" with the populated identity.  RBStart printed
            ; only "launching" earlier; this is the authoritative
            ; startup ack and avoids the pid=nil race window.
            when(RBLastPid && !prevPid
                printf("[RAMIC Bridge ipc=%L %s pid=%L] ready: bind=%s log=%s\n"
                    ipcId
                    sprintf(nil "%s (%s)" RBLastIP RBLastHost)
                    RBLastPid RBLastBind
                    if(RBDLog RBDLogPath "off")))
            ; Banner is the canonical "daemon just identified itself"
            ; event -- repaint the monitor so users don't have to hit
            ; Refresh after a fresh start.
            when(boundp('RBMonInstalled) errset(RBMRefresh())))
    )
)

procedure(RBIpcFinishHandler(ipcId data)
  ; Handler called when the Python daemon process exits
  let((exitStatus)
	exitStatus = ipcGetExitStatus(ipcId)
    printf("[RAMIC Bridge ipc=%L pid=%L port=%d] exit at (%s) state=%L\n"
        ipcId RBLastPid RBPort getCurrentTime() exitStatus)
    when(exitStatus != 0 && strlen(RBStderrBuf) > 0
        printf("[RAMIC Bridge stderr]\n%s\n" RBStderrBuf))
    RBStderrBuf = ""
    ; Daemon is gone -- repaint the monitor so it shows Down without
    ; the user having to click Refresh.
    when(boundp('RBMonInstalled) errset(RBMRefresh()))
  )
)

procedure(RBStart()
    ; Start the RAMIC Bridge daemon process.  Launches the Python daemon
    ; as a child process of Virtuoso; the actual "ready" ack is printed
    ; by RBIpcErrHandler when it sees the daemon's [RB-banner] line on
    ; stderr (which is also where RBLastPid / RBLastBind get populated).
    ; Doing it this way avoids the pid=nil race -- the startup printf
    ; would otherwise run before the banner has been read off stderr.

    ; Zombie scrub: if SKILL thinks the IPC handle is alive but no
    ; banner has ever been parsed for it (RBLastPid is nil), the daemon
    ; almost certainly died without releasing the IPC bookkeeping.
    ; A real, healthy daemon populates RBLastPid via stderr banner
    ; within ~hundreds of ms of ipcBeginProcess returning.  Reset SKILL
    ; state so we don't loop forever printing "already running" against
    ; a dead daemon.
    when(boundp('RBIpc) && ipcIsAliveProcess(RBIpc) && !RBLastPid
        printf("[RAMIC Bridge] zombie detected (ipc %L alive, no banner); resetting\n" RBIpc)
        errset(ipcKillProcess(RBIpc))
        RBIpc = 'unbound
        RBLastBind = ""
        RBLastHost = ""
        RBLastIP = ""
        RBStatCount = 0
        RBStatErrors = 0
        RBStatUptime = 0)

    if(boundp('RBIpc) && ipcIsAliveProcess(RBIpc) then
        printf("[RAMIC Bridge ipc=%L pid=%L running_bind=%s] already running; load() does not replace a running daemon; current config port=%d\n"
            RBIpc RBLastPid
            if(RBLastBind && strlen(RBLastBind) > 0 RBLastBind "unknown")
            RBPort)
        printf("[RAMIC Bridge] To switch user/port: run RBStop() or RBStopAll(), then load setup again.\n")
    else
        ; Clear leftover banner state so the new daemon's banner is
        ; recognised as the first-of-its-lifetime by RBIpcErrHandler.
        RBLastPid = nil
        RBLastBind = ""
        RBLastHost = ""
        RBLastIP = ""
        RBStatCount = 0
        RBStatErrors = 0
        RBStatUptime = 0
        prog((host logpath)
            ; Daemon binds loopback only by default (config catalog §2.3).
            host = "127.0.0.1"
            ; Set log path if logging is enabled
            if(RBDLog then
                logpath = RBDLogPath
            else
                logpath = ""
            )
            ; Start the Python daemon process with IPC handlers.
            ; Use "env -u" to strip Virtuoso's LD_LIBRARY_PATH / LD_PRELOAD
            ; so the system Python links against its own libs, not Virtuoso's
            ; bundled (and often incompatible) copies.
            RBIpc = ipcBeginProcess(sprintf(nil "/usr/bin/env -u LD_LIBRARY_PATH -u LD_PRELOAD stdbuf -oL %s -u %L %L %L %L %L" RBPython RBDPath host RBPort if(boundp('RBDToken) && RBDToken RBDToken "") RBTempDir) "" 'RBIpcDataHandler 'RBIpcErrHandler 'RBIpcFinishHandler logpath)
        )
        printf("[RAMIC Bridge ipc=%L] launching daemon (bind=127.0.0.1:%d) at (%s)\n"
            RBIpc
            RBPort
            getCurrentTime())
    )
)

procedure(RBStop()
    ; Stop the RAMIC Bridge daemon process
	if(boundp('RBIpc) && ipcIsAliveProcess(RBIpc) then
		printf("[RAMIC Bridge ipc=%L pid=%L port=%d] stopping\n"
			RBIpc RBLastPid RBPort)
		ipcKillProcess(RBIpc)
	else
		printf("[RAMIC Bridge] already down\n")
	)
)

procedure(RBStopAll()
    ; Emergency function to kill **the current user's** RAMIC Bridge
    ; daemon processes only.  Earlier versions used ``pgrep -f`` without
    ; ``-u``, which scanned every UID on the host and tried to kill
    ; other users' daemons -- yielding "permission denied" noise and
    ; (worst case) terminating an unrelated user's bridge if both ran
    ; under the same account.
    ;
    ; 1. Release Virtuoso's IPC bookkeeping for the live handle (if any)
    ; 2. Match daemon processes belonging to ``$USER`` only, by script
    ;    filename (ramic_bridge_daemon_[23]).
    ; 3. SIGTERM, wait 2s, then SIGKILL holdouts.
    ; 4. Free the port: fuser only kills sockets the caller owns; ss/lsof
    ;    fallbacks just *show* the holder.
    ; 5. Reset Skill-side IPC state and stderr buffer.
    if(boundp('RBIpc) && RBIpc != 'unbound then
        errset(ipcKillProcess(RBIpc)))
    sh(sprintf(nil
        "echo \"[RAMIC StopAll] user=$USER scope=own-uid port=%d\" >&2; pids=$(pgrep -u \"$USER\" -f 'ramic_bridge_daemon_[23]'); if [ -n \"$pids\" ]; then echo \"[RAMIC StopAll] killing pids: $pids\" >&2; echo \"$pids\" | xargs -r kill; sleep 2; pids2=$(pgrep -u \"$USER\" -f 'ramic_bridge_daemon_[23]'); [ -n \"$pids2\" ] && echo \"$pids2\" | xargs -r kill -9; else echo \"[RAMIC StopAll] no own daemon processes\" >&2; fi; if command -v fuser >/dev/null 2>&1; then fuser -k %d/tcp 2>/dev/null; elif command -v ss >/dev/null 2>&1; then ss -tlnp 2>/dev/null | awk -v p=%d '$4 ~ \":\"p\"$\"' >&2; elif command -v lsof >/dev/null 2>&1; then lsof -iTCP:%d -sTCP:LISTEN >&2; fi"
        RBPort RBPort RBPort RBPort))
    RBIpc = 'unbound
    RBLastPid = nil
    RBLastHost = ""
    RBLastIP = ""
    RBStatCount = 0
    RBStatErrors = 0
    RBStatUptime = 0
    RBStderrBuf = ""
    printf("[RAMIC Bridge] RBStopAll: killed own daemons (UID-scoped, port=%d); verify: ss -tlnp | grep %d\n"
        RBPort RBPort)
)

; Auto-start the bridge when this file is loaded (no second daemon if already up)
RBStart()
